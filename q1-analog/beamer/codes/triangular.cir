* Triangular Wave Generator

.include Lm358.mod

* ── Power Supply (±2V) ──
VCC VCC 0 DC 5
VEE VEE 0 DC -5

* ── Input: ±5V square wave, 50 Hz ──
VIN IN 0 PULSE(-5 5 0 1u 1u 10m 20m)

* ── Stage 1: Integrator ──
R1 IN NINV1 10k
C1 OUT1 NINV1 1u

XU1 0 NINV1 VCC VEE OUT1 LM358/NS

* ── Stage 2: Inverting Amplifier ──
R2 OUT1 NINV2 1k
R3 OUT2 NINV2 1k

XU2 0 NINV2 VCC VEE OUT2 LM358/NS

* ── Simulation ──
.tran 0.01m 300m

.control
run
set color0 = "white"
plot V(IN) V(OUT2)
.endc

.end
