* Triangular Wave Generator

.include Lm358.mod

* ── Power Supply (±5V) ──
VCC VCC 0 DC 5
VEE VEE 0 DC -5

* ── Input: ±5V square wave, 50 Hz ──
VIN IN 0 PULSE(-5 5 0 1u 1u 10m 20m)

* ── Stage 1: Integrator (inverting) ──
R1 IN N1 10k
C1 OUT1 N1 1u

XU1 0 N1 VCC VEE OUT1 LM358/NS

* ── Stage 2: Inverting Amplifier ──
R2 OUT1 N2 1k
R3 OUT2 N2 1k

XU2 0 N2 VCC VEE OUT2 LM358/NS

* ── Simulation ──
.tran 0.01m 300m

.control
run
set color0 = white
plot V(IN) V(OUT2)
.endc

.end
